** Profile: "8_CTLCurrentCTLVoltage-8_CTLCurrentCTLVoltage"  [ D:\1_WebUp\kakuninn\BD00C0A\TestCircuit\bd00c0awfp-pspicefiles\8_ctlcurrentctlvoltage\8_ctlcurrentctlvoltage.sim ]

** Creating circuit file "8_CTLCurrentCTLVoltage.cir"
** WARNING: THIS AUTOMATICALLY GENERATED FILE MAY BE OVERWRITTEN BY SUBSEQUENT SIMULATIONS

*Libraries:
* Profile Libraries :
* Local Libraries :
.LIB "../../../bdxxc0axfp.lib"
* From [PSPICE NETLIST] section of C:\SPB_Data\cdssetup\OrCAD_PSpice\17.2.0\PSpice.ini file:

*Analysis directives:
.DC LIN V_VCTL 0 26.5 0.01
.OPTIONS ADVCONV
.PROBE64 V(alias(*)) I(alias(*)) W(alias(*)) D(alias(*)) NOISE(alias(*))
.INC "..\8_CTLCurrentCTLVoltage.net"

.END
